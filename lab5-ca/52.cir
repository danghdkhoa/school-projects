I1 0 N001 0.1
R8 N001 0 33

VJMP5 N001 N002 0
RPOT3 N002 N003 {5K * k1}
VJMP6 N003 N004 0

I2 0 N004 0.5
R9 N004 0 10

.param k1=0.001
.step param k1 0.001 5 0.5
.op
.end
