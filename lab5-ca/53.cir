lab 53

I1 0 N001 0.0275

R13 N001 N002 120
VJMP9 N002 N003 0
RPOT5 N003 N004 {5K * k1}
VJMP10 N004 0 0

R14 N001 0 400

I2 0 N001 0.0125

.param k1=0.001
.step param k1 0.001 5 0.5
.op
.end
